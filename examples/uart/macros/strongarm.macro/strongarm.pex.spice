* strongarm: netlist extracted by Magic from strongarm.gds (capacitance), written by aispice 0.2.0
.subckt strongarm clk inm inp outn outp vdd vss
X0 vdd clk a_784_2284_ vdd sg13_lv_pmos ad=95f pd=0.88u as=95f ps=0.88u w=0.5u l=0.13u
X1 a_376_4072_ outp outn vss sg13_lv_nmos ad=0.34p pd=2.68u as=0.19p ps=1.38u w=1u l=0.13u
X2 outp clk vdd vdd sg13_lv_pmos ad=95f pd=0.88u as=95f ps=0.88u w=0.5u l=0.13u
X3 outn outp vdd vdd sg13_lv_pmos ad=0.19p pd=1.38u as=0.19p ps=1.38u w=1u l=0.13u
X4 vdd outn outp vdd sg13_lv_pmos ad=0.19p pd=1.38u as=0.19p ps=1.38u w=1u l=0.13u
X5 a_376_4072_ inp a_384_2284_ vss sg13_lv_nmos ad=0.38p pd=2.38u as=0.38p ps=2.38u w=2u l=0.13u
X6 a_384_2284_ inm a_784_2284_ vss sg13_lv_nmos ad=0.38p pd=2.38u as=0.38p ps=2.38u w=2u l=0.13u
X7 a_376_4072_ clk vdd vdd sg13_lv_pmos ad=95f pd=0.88u as=95f ps=0.88u w=0.5u l=0.13u
X8 outp outn a_784_2284_ vss sg13_lv_nmos ad=0.19p pd=1.38u as=0.34p ps=2.68u w=1u l=0.13u
X9 vdd vdd vdd vdd sg13_lv_pmos ad=95f pd=0.88u as=12.813p ps=97.96u w=0.5u l=0.13u
X10 a_384_2284_ vss a_384_2284_ vss sg13_lv_nmos ad=0.38p pd=2.38u as=2.52p ps=26.52u w=2u l=0.13u
X11 vdd clk a_376_4072_ vdd sg13_lv_pmos ad=95f pd=0.88u as=95f ps=0.88u w=0.5u l=0.13u
X12 vdd outp outn vdd sg13_lv_pmos ad=0.19p pd=1.38u as=0.19p ps=1.38u w=1u l=0.13u
X13 vdd vdd vdd vdd sg13_lv_pmos ad=0.19p pd=1.38u as=0 ps=0 w=1u l=0.13u
X14 a_384_2284_ inp a_376_4072_ vss sg13_lv_nmos ad=0.38p pd=2.38u as=0.38p ps=2.38u w=2u l=0.13u
X15 a_784_2284_ inm a_384_2284_ vss sg13_lv_nmos ad=0.38p pd=2.38u as=0.38p ps=2.38u w=2u l=0.13u
X16 vdd vdd vdd vdd sg13_lv_pmos ad=0.17p pd=1.68u as=0 ps=0 w=0.5u l=0.13u
X17 outn clk vdd vdd sg13_lv_pmos ad=95f pd=0.88u as=95f ps=0.88u w=0.5u l=0.13u
X18 vdd clk outp vdd sg13_lv_pmos ad=95f pd=0.88u as=95f ps=0.88u w=0.5u l=0.13u
X19 outp outn vdd vdd sg13_lv_pmos ad=0.19p pd=1.38u as=0.19p ps=1.38u w=1u l=0.13u
X20 a_784_2284_ outn outp vss sg13_lv_nmos ad=0.34p pd=2.68u as=0.19p ps=1.38u w=1u l=0.13u
X21 outn outp a_376_4072_ vss sg13_lv_nmos ad=0.19p pd=1.38u as=0.34p ps=2.68u w=1u l=0.13u
X22 vdd clk outn vdd sg13_lv_pmos ad=95f pd=0.88u as=95f ps=0.88u w=0.5u l=0.13u
X23 a_784_2284_ clk vdd vdd sg13_lv_pmos ad=95f pd=0.88u as=95f ps=0.88u w=0.5u l=0.13u
X24 a_384_2284_ vss a_384_2284_ vss sg13_lv_nmos ad=0.68p pd=4.68u as=0 ps=0 w=2u l=0.13u
X25 vss vss vss vss sg13_lv_nmos ad=0.68p pd=4.68u as=17.28p ps=0.12408m w=2u l=0.13u
X26 vdd vdd vdd vdd sg13_lv_pmos ad=0.34p pd=2.68u as=0 ps=0 w=1u l=0.13u
X27 a_384_2284_ clk vss vss sg13_lv_nmos ad=0.38p pd=2.38u as=0.38p ps=2.38u w=2u l=0.13u
X28 vss clk a_384_2284_ vss sg13_lv_nmos ad=0.38p pd=2.38u as=0.38p ps=2.38u w=2u l=0.13u
X29 vss vss vss vss sg13_lv_nmos ad=0.38p pd=2.38u as=0 ps=0 w=2u l=0.13u
C0 outn a_784_2284_ 0.08252f
C1 a_384_2284_ inm 0.03556f
C2 clk inm 0.48948f
C3 a_784_2284_ a_376_4072_ 0.20558f
C4 outn inp 1.07255f
C5 outn vdd 8.59265f
C6 a_384_2284_ a_784_2284_ 1.77175f
C7 clk a_784_2284_ 4.48491f
C8 outp inm 1.07253f
C9 inp a_376_4072_ 0.1658f
C10 vdd a_376_4072_ 1.06927f
C11 a_384_2284_ inp 0.03556f
C12 clk inp 0.48948f
C13 clk vdd 4.3301f
C14 a_784_2284_ outp 5.27635f
C15 outn a_376_4072_ 5.28741f
C16 a_784_2284_ inm 0.1658f
C17 vdd outp 8.67541f
C18 outn clk 0.20803f
C19 inp inm 0.53922f
C20 a_384_2284_ a_376_4072_ 1.77175f
C21 clk a_376_4072_ 4.48491f
C22 clk a_384_2284_ 0.11475f
C23 outn outp 5.74003f
C24 vdd a_784_2284_ 1.06927f
C25 a_376_4072_ outp 0.07148f
C26 clk outp 0.2038f
C27 inm vss 2.29797f
C28 inp vss 2.29797f
C29 outp vss 4.15913f
C30 outn vss 4.16578f
C31 clk vss 12.0355f
C32 vdd vss 7.06311f
C33 a_384_2284_ vss 7.89486f
C34 a_784_2284_ vss 1.83988f
C35 a_376_4072_ vss 1.83988f
.ends strongarm
