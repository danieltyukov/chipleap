* strongarm: netlist extracted by Magic from strongarm.gds (capacitance), written by aispice 0.2.0
.subckt strongarm clk inm inp outn outp vdd vss
X0 a_180_4552_ outp outn vss sg13_lv_nmos ad=0.19p pd=1.38u as=0.19p ps=1.38u w=1u l=0.13u
X1 a_180_4552_ inp a_392_2404_ vss sg13_lv_nmos ad=0.38p pd=2.38u as=0.38p ps=2.38u w=2u l=0.13u
X2 a_792_2404_ clk vdd vdd sg13_lv_pmos ad=95f pd=0.88u as=95f ps=0.88u w=0.5u l=0.13u
X3 outn clk vdd vdd sg13_lv_pmos ad=95f pd=0.88u as=95f ps=0.88u w=0.5u l=0.13u
X4 vdd clk outp vdd sg13_lv_pmos ad=95f pd=0.88u as=95f ps=0.88u w=0.5u l=0.13u
X5 vdd vdd vdd vdd sg13_lv_pmos ad=0.34p pd=2.68u as=12.813p ps=97.96u w=1u l=0.13u
X6 vdd outn outp vdd sg13_lv_pmos ad=0.19p pd=1.38u as=0.19p ps=1.38u w=1u l=0.13u
X7 a_792_2404_ outn outp vss sg13_lv_nmos ad=0.19p pd=1.38u as=0.19p ps=1.38u w=1u l=0.13u
X8 vss vss vss vss sg13_lv_nmos ad=0.68p pd=4.68u as=18.888p ps=0.1372m w=2u l=0.13u
X9 a_392_2404_ clk vss vss sg13_lv_nmos ad=0.38p pd=2.38u as=0.38p ps=2.38u w=2u l=0.13u
X10 a_180_4552_ vss a_180_4552_ vss sg13_lv_nmos ad=0.34p pd=2.68u as=1.365p ps=15.52u w=1u l=0.13u
X11 a_180_4552_ vss a_180_4552_ vss sg13_lv_nmos ad=0.19p pd=1.38u as=0 ps=0 w=1u l=0.13u
X12 vss clk a_392_2404_ vss sg13_lv_nmos ad=0.38p pd=2.38u as=0.38p ps=2.38u w=2u l=0.13u
X13 vdd clk a_792_2404_ vdd sg13_lv_pmos ad=95f pd=0.88u as=95f ps=0.88u w=0.5u l=0.13u
X14 a_392_2404_ inp a_180_4552_ vss sg13_lv_nmos ad=0.38p pd=2.38u as=0.38p ps=2.38u w=2u l=0.13u
X15 a_392_2404_ vss a_392_2404_ vss sg13_lv_nmos ad=0.38p pd=2.38u as=2.52p ps=26.52u w=2u l=0.13u
X16 a_180_4552_ clk vdd vdd sg13_lv_pmos ad=95f pd=0.88u as=95f ps=0.88u w=0.5u l=0.13u
X17 vss vss vss vss sg13_lv_nmos ad=0.38p pd=2.38u as=0 ps=0 w=2u l=0.13u
X18 outn outp vdd vdd sg13_lv_pmos ad=0.19p pd=1.38u as=0.19p ps=1.38u w=1u l=0.13u
X19 a_792_2404_ vss a_792_2404_ vss sg13_lv_nmos ad=0.19p pd=1.38u as=1.365p ps=15.52u w=1u l=0.13u
X20 a_792_2404_ vss a_792_2404_ vss sg13_lv_nmos ad=0.34p pd=2.68u as=0 ps=0 w=1u l=0.13u
X21 vdd vdd vdd vdd sg13_lv_pmos ad=95f pd=0.88u as=0 ps=0 w=0.5u l=0.13u
X22 a_792_2404_ inm a_392_2404_ vss sg13_lv_nmos ad=0.38p pd=2.38u as=0.38p ps=2.38u w=2u l=0.13u
X23 vdd clk a_180_4552_ vdd sg13_lv_pmos ad=95f pd=0.88u as=95f ps=0.88u w=0.5u l=0.13u
X24 vdd clk outn vdd sg13_lv_pmos ad=95f pd=0.88u as=95f ps=0.88u w=0.5u l=0.13u
X25 vdd outp outn vdd sg13_lv_pmos ad=0.19p pd=1.38u as=0.19p ps=1.38u w=1u l=0.13u
X26 vdd vdd vdd vdd sg13_lv_pmos ad=0.19p pd=1.38u as=0 ps=0 w=1u l=0.13u
X27 outp outn a_792_2404_ vss sg13_lv_nmos ad=0.19p pd=1.38u as=0.19p ps=1.38u w=1u l=0.13u
X28 outn outp a_180_4552_ vss sg13_lv_nmos ad=0.19p pd=1.38u as=0.19p ps=1.38u w=1u l=0.13u
X29 a_392_2404_ inm a_792_2404_ vss sg13_lv_nmos ad=0.38p pd=2.38u as=0.38p ps=2.38u w=2u l=0.13u
X30 a_392_2404_ vss a_392_2404_ vss sg13_lv_nmos ad=0.68p pd=4.68u as=0 ps=0 w=2u l=0.13u
X31 vdd vdd vdd vdd sg13_lv_pmos ad=0.17p pd=1.68u as=0 ps=0 w=0.5u l=0.13u
X32 outp clk vdd vdd sg13_lv_pmos ad=95f pd=0.88u as=95f ps=0.88u w=0.5u l=0.13u
X33 outp outn vdd vdd sg13_lv_pmos ad=0.19p pd=1.38u as=0.19p ps=1.38u w=1u l=0.13u
C0 a_792_2404_ outn 4.03726f
C1 clk vdd 3.41046f
C2 a_792_2404_ clk 0.13839f
C3 a_392_2404_ inm 0.04481f
C4 outp a_180_4552_ 1.03152f
C5 inm outn 0.01512f
C6 outp outn 9.66945f
C7 a_792_2404_ vdd 2.28787f
C8 clk inm 0.44043f
C9 outp clk 0.17779f
C10 inp inm 2.36613f
C11 outp inp 0.02213f
C12 a_392_2404_ a_180_4552_ 1.92515f
C13 outp vdd 8.55536f
C14 a_792_2404_ inm 0.03446f
C15 a_792_2404_ outp 2.4039f
C16 a_180_4552_ outn 2.37241f
C17 a_392_2404_ clk 0.07634f
C18 clk a_180_4552_ 4.83606f
C19 a_392_2404_ inp 0.0391f
C20 clk outn 0.23785f
C21 inp a_180_4552_ 0.03243f
C22 outp inm 0.06297f
C23 inp outn 0.96326f
C24 a_180_4552_ vdd 1.36978f
C25 a_792_2404_ a_392_2404_ 1.16996f
C26 vdd outn 3.75018f
C27 a_792_2404_ a_180_4552_ 6.5675f
C28 inm vss 1.59961f
C29 inp vss 1.41568f
C30 outp vss 5.14447f
C31 outn vss 2.63111f
C32 clk vss 7.32665f
C33 vdd vss 5.19536f
C34 a_392_2404_ vss 5.18357f
C35 a_792_2404_ vss 2.27656f
C36 a_180_4552_ vss 1.34564f
.ends strongarm
